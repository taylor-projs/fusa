// Generated by excel2rdl.py from mcusys_ciu.xlsx -- this file is
// the source of truth; feed it to rdl2reg.py.
// Excel header: BUS=APB3 ADDR_WIDTH=10 BASE_ADDR=0x0 ECC_OFFSET=0x280 REG_NUM=157
// Standard FuSa block (PASSWORD/FUSA_CTRL/MIssionIntStatusSet0/MIssionIntStatus0/MIssionIntMask0) auto-appended at ECC_OFFSET=0x280 per fusa_std_block.md v1.0; ext faults from the ExtInt sheet: none

property apb_addr_width { type = longint; component = addrmap; };
property bus_type       { type = string;  component = addrmap; };
property base_addr      { type = longint; component = addrmap; };
property ecc_offset     { type = longint; component = addrmap; };
property attr           { type = string;  component = field; };

addrmap mcusys_ciu {
    apb_addr_width = 10;
    bus_type       = "APB3";
    base_addr      = 0x0;
    ecc_offset     = 0x280;

    default regwidth = 32;

    // ---- 0x0: R_MGCR ----
    reg {
        field { sw = r; hw = r; reset = 15'h0; attr = "RO"; } reserved[31:17];
        field { sw = rw; hw = r; reset = 1'b0; attr = "RW"; } force_all_clk_on[16];
        field { sw = rw; hw = r; reset = 16'hFFFF; attr = "RW"; } MGCR[15:0];
    } R_MGCR @ 0x0;

    // ---- 0x4: R_MCUSYS_ACLK_CTRL ----
    reg {
        field { sw = r; hw = r; reset = 26'h0; attr = "RO"; } reserved[31:6];
        field { sw = r; hw = r; reset = 1'h0; attr = "RO"; } mcusys_aclk_fc_done[5];
        field { sw = rw; hw = r; reset = 5'h0; attr = "RW"; } mcusys_aclk_ctrl[4:0];
    } R_MCUSYS_ACLK_CTRL @ 0x4;

    // ---- 0x8: R_MCUSYS_PCLK_CTRL ----
    reg {
        field { sw = r; hw = r; reset = 26'h0; attr = "RO"; } reserved[31:6];
        field { sw = r; hw = r; reset = 1'h0; attr = "RO"; } mcusys_pclk_fc_done[5];
        field { sw = rw; hw = r; reset = 5'h0; attr = "RW"; } mcusys_pclk_ctrl[4:0];
    } R_MCUSYS_PCLK_CTRL @ 0x8;

    // ---- 0xc: R_MCUSYS_RV_CORE_CLK_CTRL ----
    reg {
        field { sw = r; hw = r; reset = 26'h0; attr = "RO"; } reserved[31:6];
        field { sw = r; hw = r; reset = 1'h0; attr = "RO"; } mcusys_rv_core_clk_fc_done[5];
        field { sw = rw; hw = r; reset = 5'h0; attr = "RW"; } mcusys_rv_core_clk_ctrl[4:0];
    } R_MCUSYS_RV_CORE_CLK_CTRL @ 0xc;

    // ---- 0x10: R_MCUSYS_M85_CORE0_CLK_CTRL ----
    reg {
        field { sw = r; hw = r; reset = 26'h0; attr = "RO"; } reserved[31:6];
        field { sw = r; hw = r; reset = 1'h0; attr = "RO"; } mcusys_m85_core0_clk_fc_done[5];
        field { sw = rw; hw = r; reset = 5'h0; attr = "RW"; } mcusys_m85_core0_clk_ctrl[4:0];
    } R_MCUSYS_M85_CORE0_CLK_CTRL @ 0x10;

    // ---- 0x14: R_MCUSYS_M85_CORE1_CLK_CTRL ----
    reg {
        field { sw = r; hw = r; reset = 26'h0; attr = "RO"; } reserved[31:6];
        field { sw = r; hw = r; reset = 1'h0; attr = "RO"; } mcusys_m85_core1_clk_fc_done[5];
        field { sw = rw; hw = r; reset = 5'h0; attr = "RW"; } mcusys_m85_core1_clk_ctrl[4:0];
    } R_MCUSYS_M85_CORE1_CLK_CTRL @ 0x14;

    // ---- 0x18: R_MCUSYS_M85_CORE2_CLK_CTRL ----
    reg {
        field { sw = r; hw = r; reset = 26'h0; attr = "RO"; } reserved[31:6];
        field { sw = r; hw = r; reset = 1'h0; attr = "RO"; } mcusys_m85_core2_clk_fc_done[5];
        field { sw = rw; hw = r; reset = 5'h0; attr = "RW"; } mcusys_m85_core2_clk_ctrl[4:0];
    } R_MCUSYS_M85_CORE2_CLK_CTRL @ 0x18;

    // ---- 0x1c: R_MCUSYS_M85_CORE3_CLK_CTRL ----
    reg {
        field { sw = r; hw = r; reset = 26'h0; attr = "RO"; } reserved[31:6];
        field { sw = r; hw = r; reset = 1'h0; attr = "RO"; } mcusys_m85_core3_clk_fc_done[5];
        field { sw = rw; hw = r; reset = 5'h0; attr = "RW"; } mcusys_m85_core3_clk_ctrl[4:0];
    } R_MCUSYS_M85_CORE3_CLK_CTRL @ 0x1c;

    // ---- 0x20: R_RV_CORE_SW_RSTN ----
    reg {
        field { sw = r; hw = r; reset = 31'h0; attr = "RO"; } reserved[31:1];
        field { sw = rw; hw = r; reset = 1'b1; attr = "RW"; } rv_core_sw_rstn[0];
    } R_RV_CORE_SW_RSTN @ 0x20;

    // ---- 0x24: R_M85_CORE0_SW_RSTN ----
    reg {
        field { sw = r; hw = r; reset = 31'h0; attr = "RO"; } reserved[31:1];
        field { sw = rw; hw = r; reset = 1'b1; attr = "RW"; } m85_core0_sw_rstn[0];
    } R_M85_CORE0_SW_RSTN @ 0x24;

    // ---- 0x28: R_M85_CORE1_SW_RSTN ----
    reg {
        field { sw = r; hw = r; reset = 31'h0; attr = "RO"; } reserved[31:1];
        field { sw = rw; hw = r; reset = 1'b1; attr = "RW"; } m85_core1_sw_rstn[0];
    } R_M85_CORE1_SW_RSTN @ 0x28;

    // ---- 0x2c: R_M85_CORE2_SW_RSTN ----
    reg {
        field { sw = r; hw = r; reset = 31'h0; attr = "RO"; } reserved[31:1];
        field { sw = rw; hw = r; reset = 1'b1; attr = "RW"; } m85_core2_sw_rstn[0];
    } R_M85_CORE2_SW_RSTN @ 0x2c;

    // ---- 0x30: R_M85_CORE3_SW_RSTN ----
    reg {
        field { sw = r; hw = r; reset = 31'h0; attr = "RO"; } reserved[31:1];
        field { sw = rw; hw = r; reset = 1'b1; attr = "RW"; } m85_core3_sw_rstn[0];
    } R_M85_CORE3_SW_RSTN @ 0x30;

    // ---- 0x34: R_M85_CORE0_CFG0 ----
    reg {
        field { sw = rw; hw = r; reset = 32'h000f30a0; attr = "RW"; } m85_core0_cfg0[31:0];
    } R_M85_CORE0_CFG0 @ 0x34;

    // ---- 0x38: R_M85_CORE0_CFG1 ----
    reg {
        field { sw = rw; hw = r; reset = 32'hff154; attr = "RW"; } m85_core0_cfg1[31:0];
    } R_M85_CORE0_CFG1 @ 0x38;

    // ---- 0x3c: R_M85_CORE0_CFG2 ----
    reg {
        field { sw = rw; hw = r; reset = 32'h140; attr = "RW"; } m85_core0_cfg2[31:0];
    } R_M85_CORE0_CFG2 @ 0x3c;

    // ---- 0x40: R_M85_CORE0_CFG_NS_SYSTICK ----
    reg {
        field { sw = r; hw = r; reset = 6'h0; attr = "RO"; } reserved[31:26];
        field { sw = rw; hw = r; reset = 26'h270f; attr = "RW"; } m85_core0_cfg_ns_systick[25:0];
    } R_M85_CORE0_CFG_NS_SYSTICK @ 0x40;

    // ---- 0x44: R_M85_CORE0_CFG_S_SYSTICK ----
    reg {
        field { sw = r; hw = r; reset = 6'h0; attr = "RO"; } reserved[31:26];
        field { sw = rw; hw = r; reset = 26'h270f; attr = "RW"; } m85_core0_cfg_s_systick[25:0];
    } R_M85_CORE0_CFG_S_SYSTICK @ 0x44;

    // ---- 0x48: R_M85_CORE0_CFG_S_VECTOR ----
    reg {
        field { sw = rw; hw = r; reset = 32'h30000000; attr = "RW"; } m85_core0_cfg_s_vector[31:0];
    } R_M85_CORE0_CFG_S_VECTOR @ 0x48;

    // ---- 0x4c: R_M85_CORE0_CFG_NS_VECTOR ----
    reg {
        field { sw = rw; hw = r; reset = 32'h30000000; attr = "RW"; } m85_core0_cfg_ns_vector[31:0];
    } R_M85_CORE0_CFG_NS_VECTOR @ 0x4c;

    // ---- 0x50: R_M85_CORE0_CFG_DPTARGET_ID ----
    reg {
        field { sw = rw; hw = r; reset = 32'h0; attr = "RW"; } m85_core0_cfg_dptarget_id[31:0];
    } R_M85_CORE0_CFG_DPTARGET_ID @ 0x50;

    // ---- 0x54: R_M85_CORE1_CFG0 ----
    reg {
        field { sw = rw; hw = r; reset = 32'h000f30a0; attr = "RW"; } m85_core1_cfg0[31:0];
    } R_M85_CORE1_CFG0 @ 0x54;

    // ---- 0x58: R_M85_CORE1_CFG1 ----
    reg {
        field { sw = rw; hw = r; reset = 32'hff154; attr = "RW"; } m85_core1_cfg1[31:0];
    } R_M85_CORE1_CFG1 @ 0x58;

    // ---- 0x5c: R_M85_CORE1_CFG2 ----
    reg {
        field { sw = rw; hw = r; reset = 32'h140; attr = "RW"; } m85_core1_cfg2[31:0];
    } R_M85_CORE1_CFG2 @ 0x5c;

    // ---- 0x60: R_M85_CORE1_CFG_NS_SYSTICK ----
    reg {
        field { sw = r; hw = r; reset = 6'h0; attr = "RO"; } reserved[31:26];
        field { sw = rw; hw = r; reset = 26'h270f; attr = "RW"; } m85_core1_cfg_ns_systick[25:0];
    } R_M85_CORE1_CFG_NS_SYSTICK @ 0x60;

    // ---- 0x64: R_M85_CORE1_CFG_S_SYSTICK ----
    reg {
        field { sw = r; hw = r; reset = 6'h0; attr = "RO"; } reserved[31:26];
        field { sw = rw; hw = r; reset = 26'h270f; attr = "RW"; } m85_core1_cfg_s_systick[25:0];
    } R_M85_CORE1_CFG_S_SYSTICK @ 0x64;

    // ---- 0x68: R_M85_CORE1_CFG_S_VECTOR ----
    reg {
        field { sw = rw; hw = r; reset = 32'h30000000; attr = "RW"; } m85_core1_cfg_s_vector[31:0];
    } R_M85_CORE1_CFG_S_VECTOR @ 0x68;

    // ---- 0x6c: R_M85_CORE1_CFG_NS_VECTOR ----
    reg {
        field { sw = rw; hw = r; reset = 32'h30000000; attr = "RW"; } m85_core1_cfg_ns_vector[31:0];
    } R_M85_CORE1_CFG_NS_VECTOR @ 0x6c;

    // ---- 0x70: R_M85_CORE1_CFG_DPTARGET_ID ----
    reg {
        field { sw = rw; hw = r; reset = 32'h0; attr = "RW"; } m85_core1_cfg_dptarget_id[31:0];
    } R_M85_CORE1_CFG_DPTARGET_ID @ 0x70;

    // ---- 0x74: R_M85_CORE2_CFG0 ----
    reg {
        field { sw = rw; hw = r; reset = 32'h000f30a0; attr = "RW"; } m85_core2_cfg0[31:0];
    } R_M85_CORE2_CFG0 @ 0x74;

    // ---- 0x78: R_M85_CORE2_CFG1 ----
    reg {
        field { sw = rw; hw = r; reset = 32'hff154; attr = "RW"; } m85_core2_cfg1[31:0];
    } R_M85_CORE2_CFG1 @ 0x78;

    // ---- 0x7c: R_M85_CORE2_CFG2 ----
    reg {
        field { sw = rw; hw = r; reset = 32'h140; attr = "RW"; } m85_core2_cfg2[31:0];
    } R_M85_CORE2_CFG2 @ 0x7c;

    // ---- 0x80: R_M85_CORE2_CFG_NS_SYSTICK ----
    reg {
        field { sw = r; hw = r; reset = 6'h0; attr = "RO"; } reserved[31:26];
        field { sw = rw; hw = r; reset = 26'h270f; attr = "RW"; } m85_core2_cfg_ns_systick[25:0];
    } R_M85_CORE2_CFG_NS_SYSTICK @ 0x80;

    // ---- 0x84: R_M85_CORE2_CFG_S_SYSTICK ----
    reg {
        field { sw = r; hw = r; reset = 6'h0; attr = "RO"; } reserved[31:26];
        field { sw = rw; hw = r; reset = 26'h270f; attr = "RW"; } m85_core2_cfg_s_systick[25:0];
    } R_M85_CORE2_CFG_S_SYSTICK @ 0x84;

    // ---- 0x88: R_M85_CORE2_CFG_S_VECTOR ----
    reg {
        field { sw = rw; hw = r; reset = 32'h30000000; attr = "RW"; } m85_core2_cfg_s_vector[31:0];
    } R_M85_CORE2_CFG_S_VECTOR @ 0x88;

    // ---- 0x8c: R_M85_CORE2_CFG_NS_VECTOR ----
    reg {
        field { sw = rw; hw = r; reset = 32'h30000000; attr = "RW"; } m85_core2_cfg_ns_vector[31:0];
    } R_M85_CORE2_CFG_NS_VECTOR @ 0x8c;

    // ---- 0x90: R_M85_CORE2_CFG_DPTARGET_ID ----
    reg {
        field { sw = rw; hw = r; reset = 32'h0; attr = "RW"; } m85_core2_cfg_dptarget_id[31:0];
    } R_M85_CORE2_CFG_DPTARGET_ID @ 0x90;

    // ---- 0x94: R_M85_CORE3_CFG0 ----
    reg {
        field { sw = rw; hw = r; reset = 32'h000f30a0; attr = "RW"; } m85_core3_cfg0[31:0];
    } R_M85_CORE3_CFG0 @ 0x94;

    // ---- 0x98: R_M85_CORE3_CFG1 ----
    reg {
        field { sw = rw; hw = r; reset = 32'hff154; attr = "RW"; } m85_core3_cfg1[31:0];
    } R_M85_CORE3_CFG1 @ 0x98;

    // ---- 0x9c: R_M85_CORE3_CFG2 ----
    reg {
        field { sw = rw; hw = r; reset = 32'h140; attr = "RW"; } m85_core3_cfg2[31:0];
    } R_M85_CORE3_CFG2 @ 0x9c;

    // ---- 0xa0: R_M85_CORE3_CFG_NS_SYSTICK ----
    reg {
        field { sw = r; hw = r; reset = 6'h0; attr = "RO"; } reserved[31:26];
        field { sw = rw; hw = r; reset = 26'h270f; attr = "RW"; } m85_core3_cfg_ns_systick[25:0];
    } R_M85_CORE3_CFG_NS_SYSTICK @ 0xa0;

    // ---- 0xa4: R_M85_CORE3_CFG_S_SYSTICK ----
    reg {
        field { sw = r; hw = r; reset = 6'h0; attr = "RO"; } reserved[31:26];
        field { sw = rw; hw = r; reset = 26'h270f; attr = "RW"; } m85_core3_cfg_s_systick[25:0];
    } R_M85_CORE3_CFG_S_SYSTICK @ 0xa4;

    // ---- 0xa8: R_M85_CORE3_CFG_S_VECTOR ----
    reg {
        field { sw = rw; hw = r; reset = 32'h30000000; attr = "RW"; } m85_core3_cfg_s_vector[31:0];
    } R_M85_CORE3_CFG_S_VECTOR @ 0xa8;

    // ---- 0xac: R_M85_CORE3_CFG_NS_VECTOR ----
    reg {
        field { sw = rw; hw = r; reset = 32'h30000000; attr = "RW"; } m85_core3_cfg_ns_vector[31:0];
    } R_M85_CORE3_CFG_NS_VECTOR @ 0xac;

    // ---- 0xb0: R_M85_CORE3_CFG_DPTARGET_ID ----
    reg {
        field { sw = rw; hw = r; reset = 32'h0; attr = "RW"; } m85_core3_cfg_dptarget_id[31:0];
    } R_M85_CORE3_CFG_DPTARGET_ID @ 0xb0;

    // ---- 0xb4: R_MCUSYS_PLL1_CTRL0 ----
    reg {
        field { sw = rw; hw = r; reset = 32'h00F81053; attr = "RW"; } mcusys_pll1_ctrl0[31:0];
    } R_MCUSYS_PLL1_CTRL0 @ 0xb4;

    // ---- 0xb8: R_MCUSYS_PLL1_CTRL1 ----
    reg {
        field { sw = rw; hw = r; reset = 32'h00555555; attr = "RW"; } mcusys_pll1_ctrl1[31:0];
    } R_MCUSYS_PLL1_CTRL1 @ 0xb8;

    // ---- 0xbc: R_MCUSYS_PLL1_CTRL2 ----
    reg {
        field { sw = rw; hw = r; reset = 32'h0; attr = "RW"; } mcusys_pll1_ctrl2[31:0];
    } R_MCUSYS_PLL1_CTRL2 @ 0xbc;

    // ---- 0xc0: R_MCUSYS_PLL1_CTRL3 ----
    reg {
        field { sw = rw; hw = r; reset = 32'h0; attr = "RW"; } mcusys_pll1_ctrl3[31:0];
    } R_MCUSYS_PLL1_CTRL3 @ 0xc0;

    // ---- 0xc4: R_MCUSYS_PLL1_MON_CONFIG ----
    reg {
        field { sw = r; hw = r; reset = 28'h0; attr = "RO"; } reserved[31:4];
        field { sw = rw; hw = r; reset = 4'h0; attr = "RW"; } mcusys_pll1_mon_config[3:0];
    } R_MCUSYS_PLL1_MON_CONFIG @ 0xc4;

    // ---- 0xc8: R_MCUSYS_PLL1_DIV_EN ----
    reg {
        field { sw = r; hw = r; reset = 23'h0; attr = "RO"; } reserved[31:9];
        field { sw = rw; hw = r; reset = 1'b0; attr = "RW"; } mcusys_pll1_pw_sw[8];
        field { sw = rw; hw = r; reset = 8'hFF; attr = "RW"; } mcusys_pll1_div_en[7:0];
    } R_MCUSYS_PLL1_DIV_EN @ 0xc8;

    // ---- 0xcc: R_MCUSYS_RSVD0 ----
    reg {
        field { sw = rw; hw = r; reset = 32'h0; attr = "RW"; } mcusys_rsvd0[31:0];
    } R_MCUSYS_RSVD0 @ 0xcc;

    // ---- 0xd0: R_MCUSYS_RSVD1 ----
    reg {
        field { sw = rw; hw = r; reset = 32'h0; attr = "RW"; } mcusys_rsvd1[31:0];
    } R_MCUSYS_RSVD1 @ 0xd0;

    // ---- 0xd4: R_MCUSYS_RSVD2 ----
    reg {
        field { sw = rw; hw = r; reset = 32'h0; attr = "RW"; } mcusys_rsvd2[31:0];
    } R_MCUSYS_RSVD2 @ 0xd4;

    // ---- 0xd8: R_MCUSYS_RSVD3 ----
    reg {
        field { sw = r; hw = r; reset = 28'h0; attr = "RO"; } reserved[31:4];
        field { sw = rw; hw = r; reset = 4'h0; attr = "RW"; } mcusys_rsvd3[3:0];
    } R_MCUSYS_RSVD3 @ 0xd8;

    // ---- 0xdc: R_MCUSYS_RSVD4 ----
    reg {
        field { sw = r; hw = r; reset = 24'h0; attr = "RO"; } reserved[31:8];
        field { sw = rw; hw = r; reset = 8'hFF; attr = "RW"; } mcusys_rsvd4[7:0];
    } R_MCUSYS_RSVD4 @ 0xdc;

    // ---- 0xe0: R_MCUSYS_RSVD5 ----
    reg {
        field { sw = rw; hw = r; reset = 32'h0; attr = "RW"; } mcusys_rsvd5[31:0];
    } R_MCUSYS_RSVD5 @ 0xe0;

    // ---- 0xe4: R_ARQOS_MCU_SYS_FAB ----
    reg {
        field { sw = rw; hw = r; reset = 32'h0; attr = "RW"; } arqos_mcu_sys_fab[31:0];
    } R_ARQOS_MCU_SYS_FAB @ 0xe4;

    // ---- 0xe8: R_AWQOS_MCU_SYS_FAB ----
    reg {
        field { sw = rw; hw = r; reset = 32'h0; attr = "RW"; } awqos_mcu_sys_fab[31:0];
    } R_AWQOS_MCU_SYS_FAB @ 0xe8;

    // ---- 0xec: R_ARQOS_MCUCORE_SYS_FAB ----
    reg {
        field { sw = rw; hw = r; reset = 32'h0; attr = "RW"; } arqos_mcucore_sys_fab[31:0];
    } R_ARQOS_MCUCORE_SYS_FAB @ 0xec;

    // ---- 0xf0: R_AWQOS_MCUCORE_SYS_FAB ----
    reg {
        field { sw = rw; hw = r; reset = 32'h0; attr = "RW"; } awqos_mcucore_sys_fab[31:0];
    } R_AWQOS_MCUCORE_SYS_FAB @ 0xf0;

    // ---- 0xf4: R_M85_CORE0_CFG_DCLSCORECTL ----
    reg {
        field { sw = r; hw = r; reset = 20'h0; attr = "RO"; } reserved[31:12];
        field { sw = rw; hw = r; reset = 12'h0; attr = "RW"; } m85_core0_cfg_dclscorectl[11:0];
    } R_M85_CORE0_CFG_DCLSCORECTL @ 0xf4;

    // ---- 0xf8: R_M85_CORE1_CFG_DCLSCORECTL ----
    reg {
        field { sw = r; hw = r; reset = 20'h0; attr = "RO"; } reserved[31:12];
        field { sw = rw; hw = r; reset = 12'h0; attr = "RW"; } m85_core1_cfg_dclscorectl[11:0];
    } R_M85_CORE1_CFG_DCLSCORECTL @ 0xf8;

    // ---- 0xfc: R_M85_CORE2_CFG_DCLSCORECTL ----
    reg {
        field { sw = r; hw = r; reset = 20'h0; attr = "RO"; } reserved[31:12];
        field { sw = rw; hw = r; reset = 12'h0; attr = "RW"; } m85_core2_cfg_dclscorectl[11:0];
    } R_M85_CORE2_CFG_DCLSCORECTL @ 0xfc;

    // ---- 0x100: R_M85_CORE3_CFG_DCLSCORECTL ----
    reg {
        field { sw = r; hw = r; reset = 20'h0; attr = "RO"; } reserved[31:12];
        field { sw = rw; hw = r; reset = 12'h0; attr = "RW"; } m85_core3_cfg_dclscorectl[11:0];
    } R_M85_CORE3_CFG_DCLSCORECTL @ 0x100;

    // ---- 0x104: R_AUD_SPARE_IN ----
    reg {
        field { sw = r; hw = r; reset = 32'h0; attr = "RO"; } aud_spare_in[31:0];
    } R_AUD_SPARE_IN @ 0x104;

    // ---- 0x108: R_GMAC0_SPEED_MODE ----
    reg {
        field { sw = r; hw = r; reset = 19'h0; attr = "RO"; } reserved[31:13];
        field { sw = rw; hw = r; reset = 2'h0; attr = "RW"; } gmac0_clk_1588_sel[12:11];
        field { sw = rw; hw = r; reset = 1'b0; attr = "RW"; } gmac0_refclk_sel[10];
        field { sw = rw; hw = r; reset = 1'b0; attr = "RW"; } gmac0_1588_clk_en[9];
        field { sw = rw; hw = r; reset = 1'b0; attr = "RW"; } gmac0_rgmii_txc_src_sel[8];
        field { sw = rw; hw = r; reset = 4'h0; attr = "RW"; } gmac0_phy_intf_sel_i[7:4];
        field { sw = rw; hw = r; reset = 1'b0; attr = "RW"; } gmac0_rx_refclk_phase_sel[3];
        field { sw = rw; hw = r; reset = 1'b0; attr = "RW"; } gmac0_rmii_refclk_phase_sel[2];
        field { sw = rw; hw = r; reset = 2'h0; attr = "RW"; } gmac0_speed_mode[1:0];
    } R_GMAC0_SPEED_MODE @ 0x108;

    // ---- 0x10c: R_GMAC0_RGMII_RXC_DLINE_PU ----
    reg {
        field { sw = r; hw = r; reset = 3'h0; attr = "RO"; } reserved[31:29];
        field { sw = rw; hw = r; reset = 20'h0; attr = "RW"; } gmac0_rgmii_rxc_dline_adj[28:9];
        field { sw = rw; hw = r; reset = 8'h0; attr = "RW"; } gmac0_rgmii_rxc_dline_range[8:1];
        field { sw = rw; hw = r; reset = 1'b0; attr = "RW"; } gmac0_rgmii_rxc_dline_pu[0];
    } R_GMAC0_RGMII_RXC_DLINE_PU @ 0x10c;

    // ---- 0x110: R_GMAC0_RGMII_TXC_DLINE_PU ----
    reg {
        field { sw = r; hw = r; reset = 3'h0; attr = "RO"; } reserved[31:29];
        field { sw = rw; hw = r; reset = 20'h0; attr = "RW"; } gmac0_rgmii_txc_dline_adj[28:9];
        field { sw = rw; hw = r; reset = 8'h0; attr = "RW"; } gmac0_rgmii_txc_dline_range[8:1];
        field { sw = rw; hw = r; reset = 1'b0; attr = "RW"; } gmac0_rgmii_txc_dline_pu[0];
    } R_GMAC0_RGMII_TXC_DLINE_PU @ 0x110;

    // ---- 0x114: R_GMAC1_SPEED_MODE ----
    reg {
        field { sw = r; hw = r; reset = 19'h0; attr = "RO"; } reserved[31:13];
        field { sw = rw; hw = r; reset = 2'h0; attr = "RW"; } gmac1_clk_1588_sel[12:11];
        field { sw = rw; hw = r; reset = 1'b0; attr = "RW"; } gmac1_refclk_sel[10];
        field { sw = rw; hw = r; reset = 1'b0; attr = "RW"; } gmac1_1588_clk_en[9];
        field { sw = rw; hw = r; reset = 1'b0; attr = "RW"; } gmac1_rgmii_txc_src_sel[8];
        field { sw = rw; hw = r; reset = 4'h0; attr = "RW"; } gmac1_phy_intf_sel_i[7:4];
        field { sw = rw; hw = r; reset = 1'b0; attr = "RW"; } gmac1_rx_refclk_phase_sel[3];
        field { sw = rw; hw = r; reset = 1'b0; attr = "RW"; } gmac1_rmii_refclk_phase_sel[2];
        field { sw = rw; hw = r; reset = 2'h0; attr = "RW"; } gmac1_speed_mode[1:0];
    } R_GMAC1_SPEED_MODE @ 0x114;

    // ---- 0x118: R_GMAC1_RGMII_RXC_DLINE_PU ----
    reg {
        field { sw = r; hw = r; reset = 3'h0; attr = "RO"; } reserved[31:29];
        field { sw = rw; hw = r; reset = 20'h0; attr = "RW"; } gmac1_rgmii_rxc_dline_adj[28:9];
        field { sw = rw; hw = r; reset = 8'h0; attr = "RW"; } gmac1_rgmii_rxc_dline_range[8:1];
        field { sw = rw; hw = r; reset = 1'b0; attr = "RW"; } gmac1_rgmii_rxc_dline_pu[0];
    } R_GMAC1_RGMII_RXC_DLINE_PU @ 0x118;

    // ---- 0x11c: R_GMAC1_RGMII_TXC_DLINE_PU ----
    reg {
        field { sw = r; hw = r; reset = 3'h0; attr = "RO"; } reserved[31:29];
        field { sw = rw; hw = r; reset = 20'h0; attr = "RW"; } gmac1_rgmii_txc_dline_adj[28:9];
        field { sw = rw; hw = r; reset = 8'h0; attr = "RW"; } gmac1_rgmii_txc_dline_range[8:1];
        field { sw = rw; hw = r; reset = 1'b0; attr = "RW"; } gmac1_rgmii_txc_dline_pu[0];
    } R_GMAC1_RGMII_TXC_DLINE_PU @ 0x11c;

    // ---- 0x120: R_REGIN_GMAC0_SYS_RST_N ----
    reg {
        field { sw = r; hw = r; reset = 18'h0; attr = "RO"; } reserved[31:14];
        field { sw = rw; hw = r; reset = 4'h0; attr = "RW"; } regin_gmac0_sbd_pc_tim_wdw_i[13:10];
        field { sw = rw; hw = r; reset = 2'h0; attr = "RW"; } regin_gmac0_mcgr_dma_ack_i[9:8];
        field { sw = rw; hw = r; reset = 2'h0; attr = "RW"; } regin_gmac0_mcg_pst_trig_i[7:6];
        field { sw = rw; hw = r; reset = 1'b0; attr = "RW"; } regin_gmac0_sbd_pmac_hold_i[5];
        field { sw = rw; hw = r; reset = 1'b1; attr = "RW"; } regin_gmac0_csysreq_i[4];
        field { sw = rw; hw = r; reset = 1'b0; attr = "RW"; } regin_gmac0_pwr_down_ctrl_i[3];
        field { sw = rw; hw = r; reset = 1'b0; attr = "RW"; } regin_gmac0_pwr_clamp_ctrl_i[2];
        field { sw = rw; hw = r; reset = 1'b0; attr = "RW"; } regin_gmac0_pwr_isolate_i[1];
        field { sw = rw; hw = r; reset = 1'b0; attr = "RW"; } regin_gmac0_sys_rst_n[0];
    } R_REGIN_GMAC0_SYS_RST_N @ 0x120;

    // ---- 0x124: R_REGIN_GMAC0_CLK_GATE ----
    reg {
        field { sw = r; hw = r; reset = 16'h0; attr = "RO"; } reserved[31:16];
        field { sw = rw; hw = r; reset = 1'b0; attr = "RW"; } regin_gmac0_cfg_clamp_en[15];
        field { sw = rw; hw = r; reset = 13'h0; attr = "RW"; } regin_gmac0_intr_mask[14:2];
        field { sw = rw; hw = r; reset = 2'h0; attr = "RW"; } regin_gmac0_clk_gate[1:0];
    } R_REGIN_GMAC0_CLK_GATE @ 0x124;

    // ---- 0x128: R_REGOUT_GMAC0_SBD_PWR_DOWN_ACK_O ----
    reg {
        field { sw = r; hw = r; reset = 9'h0; attr = "RO"; } reserved[31:23];
        field { sw = r; hw = r; reset = 1'h0; attr = "RO"; } regout_gmac0_sbd_pwr_down_ack_o[22];
        field { sw = r; hw = r; reset = 2'h0; attr = "RO"; } regout_gmac0_mcgr_dma_req_o[21:20];
        field { sw = r; hw = r; reset = 1'h0; attr = "RO"; } regout_gmac0_ati_pmac_actv_o[19];
        field { sw = r; hw = r; reset = 1'h0; attr = "RO"; } regout_gmac0_ati_pmac_txon_o[18];
        field { sw = r; hw = r; reset = 1'h0; attr = "RO"; } regout_gmac0_ati_datatxon_o[17];
        field { sw = r; hw = r; reset = 1'h0; attr = "RO"; } regout_gmac0_cactive_o[16];
        field { sw = r; hw = r; reset = 1'h0; attr = "RO"; } regout_gmac0_csysack_o[15];
        field { sw = r; hw = r; reset = 3'h0; attr = "RO"; } regout_gmac0_sbd_w_dma_ch_no_o[14:12];
        field { sw = r; hw = r; reset = 3'h0; attr = "RO"; } regout_gmac0_sbd_aw_dma_ch_no_o[11:9];
        field { sw = r; hw = r; reset = 3'h0; attr = "RO"; } regout_gmac0_sbd_ar_dma_ch_no_o[8:6];
        field { sw = r; hw = r; reset = 1'h0; attr = "RO"; } regout_gmac0_sbd_tx_clk_gating_ctrl_o[5];
        field { sw = r; hw = r; reset = 2'h0; attr = "RO"; } regout_gmac0_mac_speed_o[4:3];
        field { sw = r; hw = r; reset = 1'h0; attr = "RO"; } regout_gmac0_rst_clk_app_n_o[2];
        field { sw = r; hw = r; reset = 1'h0; attr = "RO"; } regout_gmac0_rst_clk_rx_n_o[1];
        field { sw = r; hw = r; reset = 1'h0; attr = "RO"; } regout_gmac0_rst_clk_tx_n_o[0];
    } R_REGOUT_GMAC0_SBD_PWR_DOWN_ACK_O @ 0x128;

    // ---- 0x12c: R_REGIN_GMAC1_SYS_RST_N ----
    reg {
        field { sw = r; hw = r; reset = 18'h0; attr = "RO"; } reserved[31:14];
        field { sw = rw; hw = r; reset = 4'h0; attr = "RW"; } regin_gmac1_sbd_pc_tim_wdw_i[13:10];
        field { sw = rw; hw = r; reset = 2'h0; attr = "RW"; } regin_gmac1_mcgr_dma_ack_i[9:8];
        field { sw = rw; hw = r; reset = 2'h0; attr = "RW"; } regin_gmac1_mcg_pst_trig_i[7:6];
        field { sw = rw; hw = r; reset = 1'b0; attr = "RW"; } regin_gmac1_sbd_pmac_hold_i[5];
        field { sw = rw; hw = r; reset = 1'b1; attr = "RW"; } regin_gmac1_csysreq_i[4];
        field { sw = rw; hw = r; reset = 1'b0; attr = "RW"; } regin_gmac1_pwr_down_ctrl_i[3];
        field { sw = rw; hw = r; reset = 1'b0; attr = "RW"; } regin_gmac1_pwr_clamp_ctrl_i[2];
        field { sw = rw; hw = r; reset = 1'b0; attr = "RW"; } regin_gmac1_pwr_isolate_i[1];
        field { sw = rw; hw = r; reset = 1'b0; attr = "RW"; } regin_gmac1_sys_rst_n[0];
    } R_REGIN_GMAC1_SYS_RST_N @ 0x12c;

    // ---- 0x130: R_REGIN_GMAC1_CLK_GATE ----
    reg {
        field { sw = r; hw = r; reset = 16'h0; attr = "RO"; } reserved[31:16];
        field { sw = rw; hw = r; reset = 1'b0; attr = "RW"; } regin_gmac1_cfg_clamp_en[15];
        field { sw = rw; hw = r; reset = 13'h0; attr = "RW"; } regin_gmac1_intr_mask[14:2];
        field { sw = rw; hw = r; reset = 2'h0; attr = "RW"; } regin_gmac1_clk_gate[1:0];
    } R_REGIN_GMAC1_CLK_GATE @ 0x130;

    // ---- 0x134: R_REGOUT_GMAC1_SBD_PWR_DOWN_ACK_O ----
    reg {
        field { sw = r; hw = r; reset = 9'h0; attr = "RO"; } reserved[31:23];
        field { sw = r; hw = r; reset = 1'h0; attr = "RO"; } regout_gmac1_sbd_pwr_down_ack_o[22];
        field { sw = r; hw = r; reset = 2'h0; attr = "RO"; } regout_gmac1_mcgr_dma_req_o[21:20];
        field { sw = r; hw = r; reset = 1'h0; attr = "RO"; } regout_gmac1_ati_pmac_actv_o[19];
        field { sw = r; hw = r; reset = 1'h0; attr = "RO"; } regout_gmac1_ati_pmac_txon_o[18];
        field { sw = r; hw = r; reset = 1'h0; attr = "RO"; } regout_gmac1_ati_datatxon_o[17];
        field { sw = r; hw = r; reset = 1'h0; attr = "RO"; } regout_gmac1_cactive_o[16];
        field { sw = r; hw = r; reset = 1'h0; attr = "RO"; } regout_gmac1_csysack_o[15];
        field { sw = r; hw = r; reset = 3'h0; attr = "RO"; } regout_gmac1_sbd_w_dma_ch_no_o[14:12];
        field { sw = r; hw = r; reset = 3'h0; attr = "RO"; } regout_gmac1_sbd_aw_dma_ch_no_o[11:9];
        field { sw = r; hw = r; reset = 3'h0; attr = "RO"; } regout_gmac1_sbd_ar_dma_ch_no_o[8:6];
        field { sw = r; hw = r; reset = 1'h0; attr = "RO"; } regout_gmac1_sbd_tx_clk_gating_ctrl_o[5];
        field { sw = r; hw = r; reset = 2'h0; attr = "RO"; } regout_gmac1_mac_speed_o[4:3];
        field { sw = r; hw = r; reset = 1'h0; attr = "RO"; } regout_gmac1_rst_clk_app_n_o[2];
        field { sw = r; hw = r; reset = 1'h0; attr = "RO"; } regout_gmac1_rst_clk_rx_n_o[1];
        field { sw = r; hw = r; reset = 1'h0; attr = "RO"; } regout_gmac1_rst_clk_tx_n_o[0];
    } R_REGOUT_GMAC1_SBD_PWR_DOWN_ACK_O @ 0x134;

    // ---- 0x138: R_PCM_CLK_RES_CTRL ----
    reg {
        field { sw = r; hw = r; reset = 13'h0; attr = "RO"; } reserved[31:19];
        field { sw = rw; hw = r; reset = 19'h0; attr = "RW"; } pcm_clk_res_ctrl[18:0];
    } R_PCM_CLK_RES_CTRL @ 0x138;

    // ---- 0x13c: R_PCM0_CH0_EN ----
    reg {
        field { sw = r; hw = r; reset = 26'h0; attr = "RO"; } reserved[31:6];
        field { sw = rw; hw = r; reset = 1'h1; attr = "RW"; } pcm_apb_on[5];
        field { sw = rw; hw = r; reset = 1'h0; attr = "RW"; } pcm_mch_en[4];
        field { sw = rw; hw = r; reset = 1'h0; attr = "RW"; } pcm0_ch3_en[3];
        field { sw = rw; hw = r; reset = 1'h0; attr = "RW"; } pcm0_ch2_en[2];
        field { sw = rw; hw = r; reset = 1'h0; attr = "RW"; } pcm0_ch1_en[1];
        field { sw = rw; hw = r; reset = 1'h0; attr = "RW"; } pcm0_ch0_en[0];
    } R_PCM0_CH0_EN @ 0x13c;

    // ---- 0x140: R_MCH_ADMA_MODE ----
    reg {
        field { sw = r; hw = r; reset = 17'h0; attr = "RO"; } reserved[31:15];
        field { sw = rw; hw = r; reset = 3'h6; attr = "RW"; } adc0_adma3_mode[14:12];
        field { sw = rw; hw = r; reset = 3'h6; attr = "RW"; } adc0_adma2_mode[11:9];
        field { sw = rw; hw = r; reset = 3'h6; attr = "RW"; } adc0_adma1_mode[8:6];
        field { sw = rw; hw = r; reset = 3'h6; attr = "RW"; } adc0_adma0_mode[5:3];
        field { sw = rw; hw = r; reset = 2'h0; attr = "RW"; } mch_adma_data_num[2:1];
        field { sw = rw; hw = r; reset = 1'h0; attr = "RW"; } mch_adma_mode[0];
    } R_MCH_ADMA_MODE @ 0x140;

    // ---- 0x144: R_PCM1_CLK_RES_CTRL ----
    reg {
        field { sw = r; hw = r; reset = 13'h0; attr = "RO"; } reserved[31:19];
        field { sw = rw; hw = r; reset = 19'h0; attr = "RW"; } pcm1_clk_res_ctrl[18:0];
    } R_PCM1_CLK_RES_CTRL @ 0x144;

    // ---- 0x148: R_PCM1_CH0_EN ----
    reg {
        field { sw = r; hw = r; reset = 26'h0; attr = "RO"; } reserved[31:6];
        field { sw = rw; hw = r; reset = 1'h1; attr = "RW"; } pcm1_apb_on[5];
        field { sw = rw; hw = r; reset = 1'h0; attr = "RW"; } pcm1_mch_en[4];
        field { sw = rw; hw = r; reset = 1'h0; attr = "RW"; } pcm1_ch3_en[3];
        field { sw = rw; hw = r; reset = 1'h0; attr = "RW"; } pcm1_ch2_en[2];
        field { sw = rw; hw = r; reset = 1'h0; attr = "RW"; } pcm1_ch1_en[1];
        field { sw = rw; hw = r; reset = 1'h0; attr = "RW"; } pcm1_ch0_en[0];
    } R_PCM1_CH0_EN @ 0x148;

    // ---- 0x14c: R_MCH1_ADMA_MODE ----
    reg {
        field { sw = r; hw = r; reset = 17'h0; attr = "RO"; } reserved[31:15];
        field { sw = rw; hw = r; reset = 3'h6; attr = "RW"; } adc1_adma3_mode[14:12];
        field { sw = rw; hw = r; reset = 3'h6; attr = "RW"; } adc1_adma2_mode[11:9];
        field { sw = rw; hw = r; reset = 3'h6; attr = "RW"; } adc1_adma1_mode[8:6];
        field { sw = rw; hw = r; reset = 3'h6; attr = "RW"; } adc1_adma0_mode[5:3];
        field { sw = rw; hw = r; reset = 2'h0; attr = "RW"; } mch1_adma_data_num[2:1];
        field { sw = rw; hw = r; reset = 1'h0; attr = "RW"; } mch1_adma_mode[0];
    } R_MCH1_ADMA_MODE @ 0x14c;

    // ---- 0x150: R_DMIC0_ADMA_CLK_RES_CTRL ----
    reg {
        field { sw = r; hw = r; reset = 24'h0; attr = "RO"; } reserved[31:8];
        field { sw = rw; hw = r; reset = 8'h0; attr = "RW"; } dmic0_adma_clk_res_ctrl[7:0];
    } R_DMIC0_ADMA_CLK_RES_CTRL @ 0x150;

    // ---- 0x154: R_DMIC1_ADMA_CLK_RES_CTRL ----
    reg {
        field { sw = r; hw = r; reset = 24'h0; attr = "RO"; } reserved[31:8];
        field { sw = rw; hw = r; reset = 8'h0; attr = "RW"; } dmic1_adma_clk_res_ctrl[7:0];
    } R_DMIC1_ADMA_CLK_RES_CTRL @ 0x154;

    // ---- 0x158: R_AUD_DMIC0_GT_CTRL ----
    reg {
        field { sw = r; hw = r; reset = 12'h0; attr = "RO"; } reserved[31:20];
        field { sw = rw; hw = r; reset = 5'h10; attr = "RW"; } aud_dmic3_gt_ctrl[19:15];
        field { sw = rw; hw = r; reset = 5'h10; attr = "RW"; } aud_dmic2_gt_ctrl[14:10];
        field { sw = rw; hw = r; reset = 5'h10; attr = "RW"; } aud_dmic1_gt_ctrl[9:5];
        field { sw = rw; hw = r; reset = 5'h10; attr = "RW"; } aud_dmic0_gt_ctrl[4:0];
    } R_AUD_DMIC0_GT_CTRL @ 0x158;

    // ---- 0x15c: R_AUD_DMIC4_GT_CTRL ----
    reg {
        field { sw = r; hw = r; reset = 12'h0; attr = "RO"; } reserved[31:20];
        field { sw = rw; hw = r; reset = 5'h10; attr = "RW"; } aud_dmic7_gt_ctrl[19:15];
        field { sw = rw; hw = r; reset = 5'h10; attr = "RW"; } aud_dmic6_gt_ctrl[14:10];
        field { sw = rw; hw = r; reset = 5'h10; attr = "RW"; } aud_dmic5_gt_ctrl[9:5];
        field { sw = rw; hw = r; reset = 5'h10; attr = "RW"; } aud_dmic4_gt_ctrl[4:0];
    } R_AUD_DMIC4_GT_CTRL @ 0x15c;

    // ---- 0x160: R_MCUSYS_DBGCLK_CTRL ----
    reg {
        field { sw = r; hw = r; reset = 21'h0; attr = "RO"; } reserved[31:11];
        field { sw = r; hw = r; reset = 1'h0; attr = "RO"; } mcusys_dbgclk_fc_done[10];
        field { sw = rw; hw = r; reset = 10'h148; attr = "RW"; } mcusys_dbgclk_ctrl[9:0];
    } R_MCUSYS_DBGCLK_CTRL @ 0x160;

    // ---- 0x164: R_MCUSYS_PLL2_CTRL0 ----
    reg {
        field { sw = rw; hw = r; reset = 32'h01F81051; attr = "RW"; } mcusys_pll2_ctrl0[31:0];
    } R_MCUSYS_PLL2_CTRL0 @ 0x164;

    // ---- 0x168: R_MCUSYS_PLL2_CTRL1 ----
    reg {
        field { sw = rw; hw = r; reset = 32'h00EB851F; attr = "RW"; } mcusys_pll2_ctrl1[31:0];
    } R_MCUSYS_PLL2_CTRL1 @ 0x168;

    // ---- 0x16c: R_MCUSYS_PLL2_CTRL2 ----
    reg {
        field { sw = rw; hw = r; reset = 32'h0; attr = "RW"; } mcusys_pll2_ctrl2[31:0];
    } R_MCUSYS_PLL2_CTRL2 @ 0x16c;

    // ---- 0x170: R_MCUSYS_PLL2_CTRL3 ----
    reg {
        field { sw = rw; hw = r; reset = 32'h0; attr = "RW"; } mcusys_pll2_ctrl3[31:0];
    } R_MCUSYS_PLL2_CTRL3 @ 0x170;

    // ---- 0x174: R_MCUSYS_PLL2_MON_CONFIG ----
    reg {
        field { sw = r; hw = r; reset = 28'h0; attr = "RO"; } reserved[31:4];
        field { sw = rw; hw = r; reset = 4'h0; attr = "RW"; } mcusys_pll2_mon_config[3:0];
    } R_MCUSYS_PLL2_MON_CONFIG @ 0x174;

    // ---- 0x178: R_MCUSYS_PLL2_DIV_EN ----
    reg {
        field { sw = r; hw = r; reset = 23'h0; attr = "RO"; } reserved[31:9];
        field { sw = rw; hw = r; reset = 1'b0; attr = "RW"; } mcusys_pll2_pw_sw[8];
        field { sw = rw; hw = r; reset = 8'hFF; attr = "RW"; } mcusys_pll2_div_en[7:0];
    } R_MCUSYS_PLL2_DIV_EN @ 0x178;

    // ---- 0x17c: R_MCUSYS_PLL3_CTRL0 ----
    reg {
        field { sw = rw; hw = r; reset = 32'h01F8105E; attr = "RW"; } mcusys_pll3_ctrl0[31:0];
    } R_MCUSYS_PLL3_CTRL0 @ 0x17c;

    // ---- 0x180: R_MCUSYS_PLL3_CTRL1 ----
    reg {
        field { sw = rw; hw = r; reset = 32'h0147AE1; attr = "RW"; } mcusys_pll3_ctrl1[31:0];
    } R_MCUSYS_PLL3_CTRL1 @ 0x180;

    // ---- 0x184: R_MCUSYS_PLL3_CTRL2 ----
    reg {
        field { sw = rw; hw = r; reset = 32'h0; attr = "RW"; } mcusys_pll3_ctrl2[31:0];
    } R_MCUSYS_PLL3_CTRL2 @ 0x184;

    // ---- 0x188: R_MCUSYS_PLL3_CTRL3 ----
    reg {
        field { sw = rw; hw = r; reset = 32'h0; attr = "RW"; } mcusys_pll3_ctrl3[31:0];
    } R_MCUSYS_PLL3_CTRL3 @ 0x188;

    // ---- 0x18c: R_MCUSYS_PLL3_MON_CONFIG ----
    reg {
        field { sw = r; hw = r; reset = 28'h0; attr = "RO"; } reserved[31:4];
        field { sw = rw; hw = r; reset = 4'h0; attr = "RW"; } mcusys_pll3_mon_config[3:0];
    } R_MCUSYS_PLL3_MON_CONFIG @ 0x18c;

    // ---- 0x190: R_MCUSYS_PLL3_DIV_EN ----
    reg {
        field { sw = r; hw = r; reset = 23'h0; attr = "RO"; } reserved[31:9];
        field { sw = rw; hw = r; reset = 1'b0; attr = "RW"; } mcusys_pll3_pw_sw[8];
        field { sw = rw; hw = r; reset = 8'hFF; attr = "RW"; } mcusys_pll3_div_en[7:0];
    } R_MCUSYS_PLL3_DIV_EN @ 0x190;

    // ---- 0x194: R_MCUSYS_PLL4_CTRL0 ----
    reg {
        field { sw = rw; hw = r; reset = 32'h01783190; attr = "RW"; } mcusys_pll4_ctrl0[31:0];
    } R_MCUSYS_PLL4_CTRL0 @ 0x194;

    // ---- 0x198: R_MCUSYS_PLL4_CTRL1 ----
    reg {
        field { sw = rw; hw = r; reset = 32'h00000000; attr = "RW"; } mcusys_pll4_ctrl1[31:0];
    } R_MCUSYS_PLL4_CTRL1 @ 0x198;

    // ---- 0x19c: R_MCUSYS_PLL4_CTRL2 ----
    reg {
        field { sw = rw; hw = r; reset = 32'h0; attr = "RW"; } mcusys_pll4_ctrl2[31:0];
    } R_MCUSYS_PLL4_CTRL2 @ 0x19c;

    // ---- 0x1a0: R_MCUSYS_PLL4_CTRL3 ----
    reg {
        field { sw = rw; hw = r; reset = 32'h0; attr = "RW"; } mcusys_pll4_ctrl3[31:0];
    } R_MCUSYS_PLL4_CTRL3 @ 0x1a0;

    // ---- 0x1a4: R_MCUSYS_PLL4_MON_CONFIG ----
    reg {
        field { sw = r; hw = r; reset = 28'h0; attr = "RO"; } reserved[31:4];
        field { sw = rw; hw = r; reset = 4'h0; attr = "RW"; } mcusys_pll4_mon_config[3:0];
    } R_MCUSYS_PLL4_MON_CONFIG @ 0x1a4;

    // ---- 0x1a8: R_MCUSYS_PLL4_DIV_EN ----
    reg {
        field { sw = r; hw = r; reset = 23'h0; attr = "RO"; } reserved[31:9];
        field { sw = rw; hw = r; reset = 1'b0; attr = "RW"; } mcusys_pll4_pw_sw[8];
        field { sw = rw; hw = r; reset = 8'hFF; attr = "RW"; } mcusys_pll4_div_en[7:0];
    } R_MCUSYS_PLL4_DIV_EN @ 0x1a8;

    // ---- 0x1ac: R_AXI_SRAM_CONTROL ----
    reg {
        field { sw = r; hw = r; reset = 26'h0; attr = "RO"; } reserved[31:6];
        field { sw = rw; hw = r; reset = 2'h0; attr = "RW"; } axi_sram_gating_en[5:4];
        field { sw = rw; hw = r; reset = 4'h0; attr = "RW"; } axi_sram_control[3:0];
    } R_AXI_SRAM_CONTROL @ 0x1ac;

    // ---- 0x1b0: R_RV_CORE4_CFG ----
    reg {
        field { sw = rw; hw = r; reset = 32'h000b0068; attr = "RW"; } rv_core4_cfg[31:0];
    } R_RV_CORE4_CFG @ 0x1b0;

    // ---- 0x1b4: R_RV_RESET_VECTOR ----
    reg {
        field { sw = rw; hw = r; reset = 32'h10000000; attr = "RW"; } rv_reset_vector[31:0];
    } R_RV_RESET_VECTOR @ 0x1b4;

    // ---- 0x1b8: R_RV_HART_ID ----
    reg {
        field { sw = r; hw = r; reset = 22'h0; attr = "RO"; } reserved[31:10];
        field { sw = rw; hw = r; reset = 10'h0; attr = "RW"; } rv_hart_id[9:0];
    } R_RV_HART_ID @ 0x1b8;

    // ---- 0x1bc: R_RV_STOP_ON_RESET ----
    reg {
        field { sw = r; hw = r; reset = 31'h0; attr = "RO"; } reserved[31:1];
        field { sw = rw; hw = r; reset = 1'h0; attr = "RW"; } rv_stop_on_reset[0];
    } R_RV_STOP_ON_RESET @ 0x1bc;

    // ---- 0x1c0: R_RV_ECC_MSK0 ----
    reg {
        field { sw = rw; hw = r; reset = 32'h0; attr = "RW"; } rv_ecc_msk0[31:0];
    } R_RV_ECC_MSK0 @ 0x1c0;

    // ---- 0x1c4: R_RV_ECC_MSK1 ----
    reg {
        field { sw = rw; hw = r; reset = 32'h0; attr = "RW"; } rv_ecc_msk1[31:0];
    } R_RV_ECC_MSK1 @ 0x1c4;

    // ---- 0x1c8: R_RV_ECC_STATUS0 ----
    reg {
        field { sw = r; hw = r; reset = 32'h0; attr = "RO"; } rv_ecc_status0[31:0];
    } R_RV_ECC_STATUS0 @ 0x1c8;

    // ---- 0x1cc: R_RV_ECC_STATUS1 ----
    reg {
        field { sw = r; hw = r; reset = 14'h0; attr = "RO"; } reserved[31:18];
        field { sw = r; hw = r; reset = 18'h0; attr = "RO"; } rv_ecc_status1[17:0];
    } R_RV_ECC_STATUS1 @ 0x1cc;

    // ---- 0x1d0: R_RV_SAFETY_INPUT_ERROR_DCLS ----
    reg {
        field { sw = r; hw = r; reset = 26'h0; attr = "RO"; } reserved[31:6];
        field { sw = r; hw = r; reset = 2'h0; attr = "RO"; } rv_safety_input_error_dcls[5:4];
        field { sw = r; hw = r; reset = 2'h0; attr = "RO"; } rv_safety_error[3:2];
        field { sw = r; hw = r; reset = 2'h0; attr = "RO"; } rv_lockstep_mis[1:0];
    } R_RV_SAFETY_INPUT_ERROR_DCLS @ 0x1d0;

    // ---- 0x1d4: R_RV_CORE_STATUS0 ----
    reg {
        field { sw = r; hw = r; reset = 32'h0; attr = "RO"; } rv_core_status0[31:0];
    } R_RV_CORE_STATUS0 @ 0x1d4;

    // ---- 0x1d8: R_RV_CORE_STATUS1 ----
    reg {
        field { sw = r; hw = r; reset = 32'h0; attr = "RO"; } rv_core_status1[31:0];
    } R_RV_CORE_STATUS1 @ 0x1d8;

    // ---- 0x1dc: R_RV_CORE_STATUS2 ----
    reg {
        field { sw = r; hw = r; reset = 32'h0; attr = "RO"; } rv_core_status2[31:0];
    } R_RV_CORE_STATUS2 @ 0x1dc;

    // ---- 0x1e0: R_RV_CORE_STATUS3 ----
    reg {
        field { sw = r; hw = r; reset = 32'h0; attr = "RO"; } rv_core_status3[31:0];
    } R_RV_CORE_STATUS3 @ 0x1e0;

    // ---- 0x1e4: R_RV_CORE_STATUS4 ----
    reg {
        field { sw = r; hw = r; reset = 32'h0; attr = "RO"; } rv_core_status4[31:0];
    } R_RV_CORE_STATUS4 @ 0x1e4;

    // ---- 0x1e8: R_RV_CORE_STATUS5 ----
    reg {
        field { sw = r; hw = r; reset = 32'h0; attr = "RO"; } rv_core_status5[31:0];
    } R_RV_CORE_STATUS5 @ 0x1e8;

    // ---- 0x1ec: R_RV_I1_CORE_STATUS1 ----
    reg {
        field { sw = r; hw = r; reset = 32'h0; attr = "RO"; } rv_i1_core_status1[31:0];
    } R_RV_I1_CORE_STATUS1 @ 0x1ec;

    // ---- 0x1f0: R_RV_I1_CORE_STATUS2 ----
    reg {
        field { sw = r; hw = r; reset = 32'h0; attr = "RO"; } rv_i1_core_status2[31:0];
    } R_RV_I1_CORE_STATUS2 @ 0x1f0;

    // ---- 0x1f4: R_RV_I1_CORE_STATUS3 ----
    reg {
        field { sw = r; hw = r; reset = 32'h0; attr = "RO"; } rv_i1_core_status3[31:0];
    } R_RV_I1_CORE_STATUS3 @ 0x1f4;

    // ---- 0x1f8: R_RV_I1_CORE_STATUS4 ----
    reg {
        field { sw = r; hw = r; reset = 32'h0; attr = "RO"; } rv_i1_core_status4[31:0];
    } R_RV_I1_CORE_STATUS4 @ 0x1f8;

    // ---- 0x1fc: R_MEM_EMA_CFG_31_0 ----
    reg {
        field { sw = rw; hw = r; reset = 32'h45054415; attr = "RW"; } mem_ema_cfg_31_0[31:0];
    } R_MEM_EMA_CFG_31_0 @ 0x1fc;

    // ---- 0x200: R_MEM_EMA_CFG_63_32 ----
    reg {
        field { sw = rw; hw = r; reset = 32'hE4205434; attr = "RW"; } mem_ema_cfg_63_32[31:0];
    } R_MEM_EMA_CFG_63_32 @ 0x200;

    // ---- 0x204: R_MEM_EMA_CFG_95_64 ----
    reg {
        field { sw = rw; hw = r; reset = 32'h000008B94; attr = "RW"; } mem_ema_cfg_95_64[31:0];
    } R_MEM_EMA_CFG_95_64 @ 0x204;

    // ---- 0x208: R_MEM_EMA_CFG_127_96 ----
    reg {
        field { sw = rw; hw = r; reset = 32'h00000000; attr = "RW"; } mem_ema_cfg_127_96[31:0];
    } R_MEM_EMA_CFG_127_96 @ 0x208;

    // ---- 0x20c: R_REF_CLK_IO_CFG ----
    reg {
        field { sw = r; hw = r; reset = 24'h0; attr = "RO"; } reserved[31:8];
        field { sw = rw; hw = r; reset = 8'h0; attr = "RW"; } ref_clk_io_cfg[7:0];
    } R_REF_CLK_IO_CFG @ 0x20c;

    // ---- 0x210: R_GPIO_PWR_CFG ----
    reg {
        field { sw = r; hw = r; reset = 16'h0; attr = "RO"; } reserved[31:16];
        field { sw = rw; hw = r; reset = 16'h0; attr = "RW"; } gpio_pwr_cfg[15:0];
    } R_GPIO_PWR_CFG @ 0x210;

    // ---- 0x214: R_EXT_32K_IN_IO_CFG ----
    reg {
        field { sw = r; hw = r; reset = 24'h0; attr = "RO"; } reserved[31:8];
        field { sw = rw; hw = r; reset = 8'h0; attr = "RW"; } ext_32k_in_io_cfg[7:0];
    } R_EXT_32K_IN_IO_CFG @ 0x214;

    // ---- 0x218: R_MCU_TRST_N_IO_CFG ----
    reg {
        field { sw = r; hw = r; reset = 24'h0; attr = "RO"; } reserved[31:8];
        field { sw = rw; hw = r; reset = 8'h0; attr = "RW"; } mcu_trst_n_io_cfg[7:0];
    } R_MCU_TRST_N_IO_CFG @ 0x218;

    // ---- 0x21c: R_PMIC_EN_IO_CFG ----
    reg {
        field { sw = r; hw = r; reset = 24'h0; attr = "RO"; } reserved[31:8];
        field { sw = rw; hw = r; reset = 8'h0; attr = "RW"; } pmic_en_io_cfg[7:0];
    } R_PMIC_EN_IO_CFG @ 0x21c;

    // ---- 0x220: R_RESET_IN_N_IO_CFG ----
    reg {
        field { sw = r; hw = r; reset = 24'h0; attr = "RO"; } reserved[31:8];
        field { sw = rw; hw = r; reset = 8'h0; attr = "RW"; } reset_in_n_io_cfg[7:0];
    } R_RESET_IN_N_IO_CFG @ 0x220;

    // ---- 0x224: R_rsvd2_M85_C1 ----
    reg {
        field { sw = r; hw = r; reset = 23'h0; attr = "RO"; } reserved[31:9];
        field { sw = rw; hw = r; reset = 9'h0; attr = "RW"; } rsvd2_m85_c1[8:0];
    } R_rsvd2_M85_C1 @ 0x224;

    // ---- 0x228: R_rsvd3_M85_C1 ----
    reg {
        field { sw = r; hw = r; reset = 23'h0; attr = "RO"; } reserved[31:9];
        field { sw = rw; hw = r; reset = 9'h0; attr = "RW"; } rsvd3_m85_c1[8:0];
    } R_rsvd3_M85_C1 @ 0x228;

    // ---- 0x22c: R_rsvd0_M85_C2 ----
    reg {
        field { sw = r; hw = r; reset = 23'h0; attr = "RO"; } reserved[31:9];
        field { sw = rw; hw = r; reset = 9'h0; attr = "RW"; } rsvd0_m85_c2[8:0];
    } R_rsvd0_M85_C2 @ 0x22c;

    // ---- 0x230: R_rsvd1_M85_C2 ----
    reg {
        field { sw = r; hw = r; reset = 23'h0; attr = "RO"; } reserved[31:9];
        field { sw = rw; hw = r; reset = 9'h0; attr = "RW"; } rsvd1_m85_c2[8:0];
    } R_rsvd1_M85_C2 @ 0x230;

    // ---- 0x234: R_rsvd2_M85_C2 ----
    reg {
        field { sw = r; hw = r; reset = 23'h0; attr = "RO"; } reserved[31:9];
        field { sw = rw; hw = r; reset = 9'h0; attr = "RW"; } rsvd2_m85_c2[8:0];
    } R_rsvd2_M85_C2 @ 0x234;

    // ---- 0x238: R_rsvd3_M85_C2 ----
    reg {
        field { sw = r; hw = r; reset = 23'h0; attr = "RO"; } reserved[31:9];
        field { sw = rw; hw = r; reset = 9'h0; attr = "RW"; } rsvd3_m85_c2[8:0];
    } R_rsvd3_M85_C2 @ 0x238;

    // ---- 0x23c: R_rsvd0_M85_C3 ----
    reg {
        field { sw = r; hw = r; reset = 23'h0; attr = "RO"; } reserved[31:9];
        field { sw = rw; hw = r; reset = 9'h0; attr = "RW"; } rsvd0_m85_c3[8:0];
    } R_rsvd0_M85_C3 @ 0x23c;

    // ---- 0x240: R_rsvd1_M85_C3 ----
    reg {
        field { sw = r; hw = r; reset = 23'h0; attr = "RO"; } reserved[31:9];
        field { sw = rw; hw = r; reset = 9'h0; attr = "RW"; } rsvd1_m85_c3[8:0];
    } R_rsvd1_M85_C3 @ 0x240;

    // ---- 0x244: R_rsvd2_M85_C3 ----
    reg {
        field { sw = r; hw = r; reset = 23'h0; attr = "RO"; } reserved[31:9];
        field { sw = rw; hw = r; reset = 9'h0; attr = "RW"; } rsvd2_m85_c3[8:0];
    } R_rsvd2_M85_C3 @ 0x244;

    // ---- 0x248: R_rsvd3_M85_C3 ----
    reg {
        field { sw = r; hw = r; reset = 23'h0; attr = "RO"; } reserved[31:9];
        field { sw = rw; hw = r; reset = 9'h0; attr = "RW"; } rsvd3_m85_c3[8:0];
    } R_rsvd3_M85_C3 @ 0x248;

    // ---- 0x24c: R_rsvd0_RV_M ----
    reg {
        field { sw = r; hw = r; reset = 23'h0; attr = "RO"; } reserved[31:9];
        field { sw = rw; hw = r; reset = 9'h0; attr = "RW"; } rsvd0_rv_m[8:0];
    } R_rsvd0_RV_M @ 0x24c;

    // ---- 0x250: R_rsvd1_RV_M ----
    reg {
        field { sw = r; hw = r; reset = 23'h0; attr = "RO"; } reserved[31:9];
        field { sw = rw; hw = r; reset = 9'h0; attr = "RW"; } rsvd1_rv_m[8:0];
    } R_rsvd1_RV_M @ 0x250;

    // ---- 0x254: R_rsvd2_RV_M ----
    reg {
        field { sw = r; hw = r; reset = 23'h0; attr = "RO"; } reserved[31:9];
        field { sw = rw; hw = r; reset = 9'h0; attr = "RW"; } rsvd2_rv_m[8:0];
    } R_rsvd2_RV_M @ 0x254;

    // ---- 0x258: R_rsvd3_RV_M ----
    reg {
        field { sw = r; hw = r; reset = 23'h0; attr = "RO"; } reserved[31:9];
        field { sw = rw; hw = r; reset = 9'h0; attr = "RW"; } rsvd3_rv_m[8:0];
    } R_rsvd3_RV_M @ 0x258;

    // ---- 0x25c: R_rsvd0_RV_S ----
    reg {
        field { sw = r; hw = r; reset = 23'h0; attr = "RO"; } reserved[31:9];
        field { sw = rw; hw = r; reset = 9'h0; attr = "RW"; } rsvd0_rv_s[8:0];
    } R_rsvd0_RV_S @ 0x25c;

    // ---- 0x260: R_rsvd1_RV_S ----
    reg {
        field { sw = r; hw = r; reset = 23'h0; attr = "RO"; } reserved[31:9];
        field { sw = rw; hw = r; reset = 9'h0; attr = "RW"; } rsvd1_rv_s[8:0];
    } R_rsvd1_RV_S @ 0x260;

    // ---- 0x264: R_rsvd2_RV_S ----
    reg {
        field { sw = r; hw = r; reset = 23'h0; attr = "RO"; } reserved[31:9];
        field { sw = rw; hw = r; reset = 9'h0; attr = "RW"; } rsvd2_rv_s[8:0];
    } R_rsvd2_RV_S @ 0x264;

    // ---- 0x268: R_rsvd3_RV_S ----
    reg {
        field { sw = r; hw = r; reset = 23'h0; attr = "RO"; } reserved[31:9];
        field { sw = rw; hw = r; reset = 9'h0; attr = "RW"; } rsvd3_rv_s[8:0];
    } R_rsvd3_RV_S @ 0x268;

    // ---- 0x26c: R_USB_CLK_CTRL ----
    reg {
        field { sw = r; hw = r; reset = 26'h0; attr = "RO"; } reserved[31:6];
        field { sw = rw; hw = r; reset = 6'b0; attr = "RW"; } usb_clk_ctrl[5:0];
    } R_USB_CLK_CTRL @ 0x26c;

    // ---- 0x270: R_USB_WK_MASK ----
    reg {
        field { sw = r; hw = r; reset = 9'h0; attr = "RO"; } reserved[31:23];
        field { sw = r; hw = r; reset = 1'h0; attr = "RO"; } usb_wk_int_status[22];
        field { sw = r; hw = r; reset = 6'h0; attr = "RO"; } usb_wk_status[21:16];
        field { sw = rw; hw = r; reset = 1'b0; attr = "RW"; } usb_id_ovrd_val[15];
        field { sw = rw; hw = r; reset = 1'b0; attr = "RW"; } usb_id_ovrd_en[14];
        field { sw = rw; hw = r; reset = 1'b0; attr = "RW"; } usb_vbus_drv[13];
        field { sw = rw; hw = r; reset = 6'b0; attr = "RW"; } usb_wk_clr[12:7];
        field { sw = rw; hw = r; reset = 1'b0; attr = "RW"; } usb_wk_int_mask[6];
        field { sw = rw; hw = r; reset = 6'b0; attr = "RW"; } usb_wk_mask[5:0];
    } R_USB_WK_MASK @ 0x270;

    // ---- 0x280: PASSWORD (ECC) ----
    reg {
        field { sw = rw; hw = r; reset = 32'h0badbeef; attr = "RW"; desc = "write key; 0x95f2d303 unlocks 0x08~0x14 writes"; } passwd[31:0];
    } PASSWORD @ 0x280;

    // ---- 0x284: FUSA_CTRL (ECC) ----
    reg {
        field { sw = r; hw = r; reset = 19'h0; attr = "RO"; } reserved[31:13];
        field { sw = rw; hw = r; reset = 1'b0; attr = "RW"; desc = "parity invert injection (SW, 2-cycle window, all banks)"; } parity_invert[12];
        field { sw = rw; hw = r; reset = 4'b0; attr = "RW"; desc = "parity pattern injection (gated by fault_injection_en)"; } parity_fault_injection[11:8];
        field { sw = r; hw = r; reset = 4'h0; attr = "RO"; } reserved_1[7:4];
        field { sw = rw; hw = r; reset = 2'b0; attr = "RW"; desc = "lockstep compare injection pattern"; } lockstep_fault_injection[3:2];
        field { sw = rw; hw = r; reset = 1'b0; attr = "RW"; desc = "injection master enable"; } fault_injection_en[1];
        field { sw = rw; hw = r; reset = 1'b0; attr = "RW"; desc = "0 = decoder bypass (fail-visible)"; } parity_decoder_enable[0];
    } FUSA_CTRL @ 0x284;

    // ---- 0x288: MIssionIntStatusSet0 (ECC) ----
    reg {
        field { sw = r; hw = r; reset = 31'h0; attr = "RO"; } reserved[31:1];
        field { sw = w; hw = r; reset = 1'b0; attr = "WO"; } parity_err_set[0];
    } MIssionIntStatusSet0 @ 0x288;

    // ---- 0x28c: MIssionIntStatus0 (ECC) ----
    reg {
        field { sw = r; hw = r; reset = 31'h0; attr = "RO"; } reserved[31:1];
        field { sw = rw; onwrite = woclr; hw = rw; reset = 1'b0; attr = "W1C"; } parity_err_status[0];
    } MIssionIntStatus0 @ 0x28c;

    // ---- 0x290: MIssionIntMask0 (ECC) ----
    reg {
        field { sw = r; hw = r; reset = 31'h0; attr = "RO"; } reserved[31:1];
        field { sw = rw; hw = r; reset = 1'b0; attr = "RW"; } parity_err_mask[0];
    } MIssionIntMask0 @ 0x290;
};
