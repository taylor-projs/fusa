// Generated by excel2rdl.py from taylor_apb_regfile.xlsx -- this file is
// the source of truth; feed it to rdl2reg.py.
// Excel header: BUS=APB3 ADDR_WIDTH=13 BASE_ADDR=0x0 ECC_OFFSET=0x100 REG_NUM=1

property apb_addr_width { type = longint; component = addrmap; };
property bus_type       { type = string;  component = addrmap; };
property base_addr      { type = longint; component = addrmap; };
property ecc_offset     { type = longint; component = addrmap; };
property attr           { type = string;  component = field; };

addrmap taylor_apb_regfile {
    apb_addr_width = 13;
    bus_type       = "APB3";
    base_addr      = 0x0;
    ecc_offset     = 0x100;

    default regwidth = 32;

    // ---- 0x0: REG_CFG0 ----
    reg {
        field { sw = rw; hw = r; reset = 32'h0; attr = "RW"; } cpu_idle_cfg[31:0];
    } REG_CFG0 @ 0x0;

    // ---- 0x100: PASSWORD (ECC) ----
    reg {
        field { sw = rw; hw = r; reset = 32'h0badbeef; attr = "RW"; } passwd[31:0];
    } PASSWORD @ 0x100;

    // ---- 0x104: FUSA_CTRL (ECC) ----
    reg {
        field { sw = r; hw = r; reset = 10'h0; attr = "RO"; } reserved[31:22];
        field { sw = r; hw = r; reset = 2'h0; attr = "RO"; } reserved_1[21:20];
        field { sw = r; hw = r; reset = 2'h0; attr = "RO"; } reserved_2[19:18];
        field { sw = r; hw = r; reset = 2'h0; attr = "RO"; } reserved_3[17:16];
        field { sw = r; hw = r; reset = 2'h0; attr = "RO"; } reserved_4[15:14];
        field { sw = r; hw = r; reset = 1'h0; attr = "RO"; } reserved_5[13];
        field { sw = rw; hw = r; reset = 1'b0; attr = "RW"; } parity_invert[12];
        field { sw = rw; hw = r; reset = 4'b0; attr = "RW"; } parity_fault_injection[11:8];
        field { sw = r; hw = r; reset = 4'h0; attr = "RO"; } reserved_6[7:4];
        field { sw = rw; hw = r; reset = 2'b0; attr = "RW"; } lockstep_fault_injection[3:2];
        field { sw = rw; hw = r; reset = 1'b0; attr = "RW"; } fault_injection_en[1];
        field { sw = rw; hw = r; reset = 1'b0; attr = "RW"; } parity_decoder_enable[0];
    } FUSA_CTRL @ 0x104;

    // ---- 0x108: MIssionIntMask0 (ECC) ----
    reg {
        field { sw = r; hw = r; reset = 25'h0; attr = "RO"; } reserved[31:7];
        field { sw = rw; hw = r; reset = 1'b1; attr = "RW"; } pd_top_noc_idlereq_time_out_mask[6];
        field { sw = rw; hw = r; reset = 1'b1; attr = "RW"; } pd_top_bisr_done_time_out_mask[5];
        field { sw = rw; hw = r; reset = 1'b1; attr = "RW"; } pd_top_bisr_busy_time_out_mask[4];
        field { sw = rw; hw = r; reset = 1'b1; attr = "RW"; } pd_top_pwr_off_time_out_mask[3];
        field { sw = rw; hw = r; reset = 1'b1; attr = "RW"; } top_pmu_signal_chk_err_mask[2];
        field { sw = rw; hw = r; reset = 1'b1; attr = "RW"; } lockstep_err_mask[1];
        field { sw = rw; hw = r; reset = 1'b1; attr = "RW"; } parity_err_mask[0];
    } MIssionIntMask0 @ 0x108;

    // ---- 0x10c: MIssionIntStatusSet0 (ECC) ----
    reg {
        field { sw = r; hw = r; reset = 25'h0; attr = "RO"; } reserved[31:7];
        field { sw = w; hw = r; reset = 1'b0; attr = "WO"; } pd_top_noc_idlereq_time_out_set[6];
        field { sw = w; hw = r; reset = 1'b0; attr = "WO"; } pd_top_bisr_done_time_out_set[5];
        field { sw = w; hw = r; reset = 1'b0; attr = "WO"; } pd_top_bisr_busy_time_out_set[4];
        field { sw = w; hw = r; reset = 1'b0; attr = "WO"; } pd_top_pwr_off_time_out_set[3];
        field { sw = w; hw = r; reset = 1'b0; attr = "WO"; } top_pmu_signal_chk_err_set[2];
        field { sw = w; hw = r; reset = 1'b0; attr = "WO"; } lockstep_err_set[1];
        field { sw = w; hw = r; reset = 1'b0; attr = "WO"; } parity_err_set[0];
    } MIssionIntStatusSet0 @ 0x10c;

    // ---- 0x110: MIssionIntStatus0 (ECC) ----
    reg {
        field { sw = r; hw = r; reset = 25'h0; attr = "RO"; } reserved[31:7];
        field { sw = rw; onwrite = woclr; hw = rw; reset = 1'b0; attr = "W1C"; } pd_top_noc_idlereq_time_out_status[6];
        field { sw = rw; onwrite = woclr; hw = rw; reset = 1'b0; attr = "W1C"; } pd_top_bisr_done_time_out_status[5];
        field { sw = rw; onwrite = woclr; hw = rw; reset = 1'b0; attr = "W1C"; } pd_top_bisr_busy_time_out_status[4];
        field { sw = rw; onwrite = woclr; hw = rw; reset = 1'b0; attr = "W1C"; } pd_top_pwr_off_time_out_status[3];
        field { sw = rw; onwrite = woclr; hw = rw; reset = 1'b0; attr = "W1C"; } top_pmu_signal_chk_err_status[2];
        field { sw = rw; onwrite = woclr; hw = rw; reset = 1'b0; attr = "W1C"; } lockstep_err_status[1];
        field { sw = rw; onwrite = woclr; hw = rw; reset = 1'b0; attr = "W1C"; } parity_err_status[0];
    } MIssionIntStatus0 @ 0x110;
};
